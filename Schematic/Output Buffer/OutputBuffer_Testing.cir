* Qucs 26.1.1  /foss/designs/LNA/MkIII/Schematic/Output Buffer/OutputBuffer_Transient_Testing.sch
.INCLUDE "/foss/tools/qucs-s/share/qucs-s/xspice_cmlib/include/ngspice_mathfunc.inc"
.INCLUDE "/foss/pdks/ciel/gf180mcu/versions/026824c7969ce6f4fc9678e6ca04b0a06a596c4b/gf180mcuD/libs.tech/ngspice/design.ngspice"
.LIB "/foss/pdks/ciel/gf180mcu/versions/026824c7969ce6f4fc9678e6ca04b0a06a596c4b/gf180mcuD/libs.tech/ngspice/sm141064.ngspice" typical
.SUBCKT OutputBufferMkIV _net0 _net1 _net3 _net2
X21 _net0  _net1  _net3  0 nfet_06v0 L=0.6u W=10.00u nf=1 ad='int((nf+1)/2) * W/nf * 0.18u' as='int((nf+2)/2) * W/nf * 0.18u' pd='2*int((nf+1)/2) * (W/nf + 0.18u)' ps='2*int((nf+2)/2) * (W/nf + 0.18u)' nrd='0.18u / W' nrs='0.18u / W' sa=0 sb=0 sd=0
X22 _net3  _net2  0  0 nfet_06v0 L=0.6u W=10.00u nf=1 ad='int((nf+1)/2) * W/nf * 0.18u' as='int((nf+2)/2) * W/nf * 0.18u' pd='2*int((nf+1)/2) * (W/nf + 0.18u)' ps='2*int((nf+2)/2) * (W/nf + 0.18u)' nrd='0.18u / W' nrs='0.18u / W' sa=0 sb=0 sd=0
.ENDS

R2 _net0 _net1  50K tc1=0.0 tc2=0.0
V5 input 0 DC 0 SIN(0 240M 1G 0 0 0) AC 240M ACPHASE 0
C2 input _net1  10P
C3 output_dc output  10P
V7 _net2 0 DC 5
V6 _net0 0 DC 2
R1 0 output  50 tc1=0.0 tc2=0.0
XSUB1 _net2 _net1 output_dc _net3 OutputBufferMkIV
X3 _net3  _net3  0  0 nfet_06v0 L=0.6u W=10.00u nf=1 ad='int((nf+1)/2) * W/nf * 0.18u' as='int((nf+2)/2) * W/nf * 0.18u' pd='2*int((nf+1)/2) * (W/nf + 0.18u)' ps='2*int((nf+2)/2) * (W/nf + 0.18u)' nrd='0.18u / W' nrs='0.18u / W' sa=0 sb=0 sd=0
I2 _net2 _net3 DC 3M

.control

tran 1.0005e-11 2e-08 0
write spice4qucs.tr1.plot v(input) v(output) v(output_dc)
destroy all
reset

op
print v(input) v(output) v(output_dc)   > spice4qucs.dc1.ngspice.dc.print
destroy all
reset

tran 1.66667e-10 1e-06 0
set specwindow=hanning
linearize v(input) v(output) v(output_dc)
fft v(input) v(output) v(output_dc)
write spice4qucs.fft1.plot v(input) v(output) v(output_dc)
destroy all
reset

exit
.endc
.END
